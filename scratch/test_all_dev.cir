* Test OP vectors
V1 1 0 10
R1 1 2 1k
D1 2 0 D1N4148
.model D1N4148 D(Is=2.52n Rs=0.568 N=1.752 Cjo=4p M=0.4 tt=20n)
.options savecurrents
.save all @r1[i] @r1[p] @d1[id] @d1[vd]
.op
.end
