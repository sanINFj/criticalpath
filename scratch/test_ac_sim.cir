* Test AC Simulation with AC 1
V1 in 0 SINE(0 1 1k) AC 1
R1 in out 1k
C1 out 0 100n
.ac dec 10 10 1Meg
.save all
.end
